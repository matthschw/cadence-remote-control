(load "./src/main/skill/EDcdsRemoteControl.il")
(ipcSkillProcess "java -cp ./target/classes/ edlab.eda.cadence.rc.session.CadenceSocket")
