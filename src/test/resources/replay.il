(load "./src/main/skill/EDcdsRC.il")
(ipcSkillProcess "java -cp ./target/classes/ edlab.eda.cadence.rc.session.CadenceSocket")
